;====================Set to Maestro mode assembler =============================
ocnSetXLMode("assembler")
ocnxlProjectDir( "./simulation" )
ocnxlTargetCellView( "ee610_fall2025_jc9253_lib" "tb_ota_stage" "maestro" )
ocnxlResultsLocation( "" )
ocnxlSimResultsLocation( "" )
ocnxlMaxJobFail( 20 )

;====================== Tests setup ============================================

;---------- Test "OTA_DC_TRANS_ac" -------------
ocnxlBeginTest("OTA_DC_TRANS_ac")
simulator( 'spectre )
design( "ee610_fall2025_jc9253_lib" "tb_ota_stage" "schematic")
modelFile(
    '("/classes/ee620/tech/cds/gpdk045/GPDK045_v5/TECH/GPDK045/gpdk045_v_5_0/gpdk045/../models/spectre/gpdk045.scs" "tt")
)
analysis('dc ?saveOppoint t  )
desVar(	  "Fin" 10M	)
desVar(	  "IREF_OUT" 10u	)
desVar(	  "VIN_AC" 1.2u	)
desVar(	  "VIN_DC" 1.6	)
desVar(	  "Wu" 1u	)
envOption(
	'analysisOrder  list("dc" "tran" "ac" "pz" "dcmatch" "stb" "envlp" "lf" "noise" "xf" "sp" "pss" "pac" "pstb" "pnoise" "pxf" "psp" "qpss" "qpac" "qpnoise" "qpxf" "qpsp" "hb" "hbac" "hbstb" "hbnoise" "hbxf" "sens" "acmatch")
)
option(	'pzSeverity  "None"
	'noiseSeverity  "None"
	'spSeverity  "None"
	'acSeverity  "None"
	'dcOpSeverity  "None"
	'dcSeverity  "None"
	'tranSeverity  "None"
)
saveOption( ?infoOptions list(list("modelParameter" "models" "rawfile" "" "" "" t) list("element" "inst" "rawfile" "" "" "" t) list("outputParameter" "output" "rawfile" "" "" "" t) list("designParamVals" "parameters" "rawfile" "" "" "" t) list("primitives" "primitives" "rawfile" "" "" "" t) list("subckts" "subckts" "rawfile" "" "" "" t) list("asserts" "assert" "rawfile" "" "" "" nil) list("extremeinfo" "all" "logfile" "" "yes" "" nil) list("allcap" "allcap" "file" "" "" "" nil) list("simStatistics" "simstat" "rawfile" "" "" "" nil) list("<Click_To_Add>" "none" "rawfile" "" "" "" nil) ) )
save( 'v "/net2" "/vin2" "/vin1" "/ota/IREF_OUT" "/ota/vg_bias" "/ota/av1" "/ota/av2" "/ota/av3" "/vout" )
temp( 27 )
;;; INPUT STAGE
ocnxlOutputSignal( "/vin2" ?plot t ?save t)
ocnxlOutputSignal( "/vin1" ?plot t ?save t)
ocnxlOutputExpr( "(ymax(VT(\"/vin2\")) - ymin(VT(\"/vin2\")))" ?name "VIN_PP" ?plot t ?save t ?evalType 'point)
ocnxlOutputExpr( "(VT(\"/vin2\") - average(VT(\"/vin2\")))" ?name "VIN_NoDC" ?plot t ?save t ?evalType 'point)
ocnxlOutputExpr( "cross(VIN_NoDC 0 5 \"rising\" nil nil nil)" ?name "VIN_Cros" ?plot t ?save t ?evalType 'point)

ocnxlOutputSignal( "/vg_bias" ?name "bias point voltage" ?plot t ?save t)
ocnxlOutputSignal( "/ota/IREF_OUT" ?plot t ?save t)
ocnxlOutputSignal( "/mirror_headroom" ?plot t ?save t)

;;; FIRST STAGE DIFF AMP GAIN GM4(r0 4//r0 1)
ocnxlOutputExpr( "(1 / OP(\"/M4\" \"gds\"))" ?name "M4_r0" ?plot t ?evalType 'point)
ocnxlOutputExpr( "(1 / OP(\"/M1\" \"gds\"))" ?name "M1_r0" ?plot t ?evalType 'point)
ocnxlOutputExpr( "OP(\"/ota/M4\" \"gm\")" ?name "gm4" ?plot t ?evalType 'point)
ocnxlOutputExpr( "gm4 * 1/(1/M4_r0 + 1/M1_r0)" ?name "Expected Gain" ?plot t ?evalType 'point)
ocnxlOutputExpr( "(OP(\"/ota/M4\" \"gm\") / OP(\"/ota/M4\" \"id\"))" ?name "gm4/ID" ?plot t ?evalType 'point)

ocnxlOutputExpr( "(ymax(VT(\"/ota/av1\")) - ymin(VT(\"/ota/av1\")))/(VIN_PP)" ?name "Actual Gain" ?plot t ?evalType 'point)

;;; SECOND STAGE INVERSION
ocnxlOutputExpr( "OP(\"/ota/M5\" \"gm\")" ?name "gm5" ?plot t ?evalType 'point)
ocnxlOutputExpr( "OP(\"/ota/M6\" \"gm\")" ?name "gm6" ?plot t ?evalType 'point)
ocnxlOutputExpr( "gm6/gm5" ?name "Expected Gain" ?plot t ?evalType 'point)

ocnxlOutputExpr( "(ymax(VT(\"/ota/av2\")) - ymin(VT(\"/ota/av2\")))/(ymax(VT(\"/ota/av1\")) - ymin(VT(\"/ota/av1\")))" ?name "Actual Gain" ?plot t ?evalType 'point)

;;; THIRD STATE MAIN GAIN
ocnxlOutputExpr( "OP(\"/ota/M7\" \"gm\")" ?name "gm7" ?plot t ?evalType 'point)
ocnxlOutputExpr( "(1 / OP(\"/M7\" \"gds\"))" ?name "M7_r0" ?plot t ?evalType 'point)
ocnxlOutputExpr( "(1 / OP(\"/M2\" \"gds\"))" ?name "M2_r0" ?plot t ?evalType 'point)
ocnxlOutputExpr( "gm7 * 1/(1/M7_r0 + 1/M2_r0)" ?name "Expected Gain" ?plot t ?evalType 'point)

ocnxlOutputExpr( "(ymax(VT(\"/ota/av3\")) - ymin(VT(\"/ota/av3\")))/(ymax(VT(\"/ota/av1\")) - ymin(VT(\"/ota/av1\")))" ?name "Actual Gain" ?plot t ?evalType 'point)

;;; VOUT
ocnxlOutputExpr( "(ymax(VT(\"/vout\")) - ymin(VT(\"/vout\")))" ?name "VOUT_PP" ?plot t ?save t ?evalType 'point)
ocnxlOutputExpr( "(VT(\"/vout\") - average(VT(\"/vout\")))" ?name "VOUT_NoDC" ?plot t ?save t ?evalType 'point)
ocnxlOutputExpr( "(VT(\"/ota/av1\") - average(VT(\"/ota/av1\")))" ?name "av1_NoDC" ?plot t ?evalType 'point)
ocnxlOutputExpr( "(VT(\"/ota/av2\") - average(VT(\"/ota/av2\")))" ?name "av2_NoDC" ?plot t ?evalType 'point)
ocnxlOutputExpr( "(VT(\"/ota/av3\") - average(VT(\"/ota/av3\")))" ?name "av2_NoDC" ?plot t ?evalType 'point)

ocnxlOutputExpr( "(VOUT_PP / VIN_PP)" ?name "Av" ?plot t ?evalType 'point)

ocnxlOutputExpr( "cross(VOUT_NoDC 0 5 \"rising\" nil nil nil)" ?name "VOUT_Cros" ?plot t ?save t ?evalType 'point)
ocnxlOutputExpr( "(VOUT_Cros - VIN_Cros)" ?name "cross_delta" ?plot t ?save t ?evalType 'point)
ocnxlOutputExpr( "(360 - (cross_delta * VAR(\"Fin\") * 360))" ?name "phase shift" ?plot t ?evalType 'point)
ocnxlOutputExpr( "(OP(\"/ota/M7\" \"gm\") / OP(\"/ota/M7\" \"id\"))" ?name "gm2,7" ?plot t ?evalType 'point)
ocnxlOutputExpr( "dB20(VF(\"/vout\"))" ?name "VOUT_Mag" ?plot t ?evalType 'point)
ocnxlOutputExpr( "phase(VF(\"/vout\"))" ?name "VOUT_Phase" ?plot t ?evalType 'point)
ocnxlEndTest() ; "OTA_DC_TRANS_ac"

;====================== Sweeps setup ===========================================

;====================== Model Group setup ==========================================
ocnxlModelGroup( "/classes/ee620/tech/cds/gpdk045/GPDK045_v5/TECH/GPDK045/gpdk045_v_5_0/gpdk045/../models/spectre/gpdk045.scs"
   '(
   )
)

;====================== Corners setup ==========================================
ocnxlCorner( "Typical"
   '(
      ("variable" "temperature" "27")
      ("variable" "VDD" "1.2")
      ("model" "/classes/ee620/tech/cds/gpdk045/GPDK045_v5/TECH/GPDK045/gpdk045_v_5_0/gpdk045/../models/spectre/gpdk045.scs" ?section "\"tt\"")
      ("modelGroup" "")
   )
)

;====================== Checks and Asserts setup ============================================
ocnxlPutChecksAsserts(?netlist nil)

;====================== Test v/s corners setup =================================

;====================== Job setup ==============================================
ocnxlJobSetup( '(
	"blockemail" "1"
	"communicationtimeout" "180"
	"configuretimeout" "300"
	"defaultcpuvalue" "1"
	"defaultmemoryvalue" "1000"
	"distributionmethod" "Local"
	"jobruntype" "LSCS"
	"estimatecpuvalue" ""
	"estimatememoryvalue" ""
	"estimationsimulationmode" "0"
	"lingertimeout" "300"
	"maxjobs" "1"
	"name" "Maestro Default"
	"preemptivestart" "1"
	"providecpuandmemorydata" "1"
	"reconfigureimmediately" "1"
	"runpointsvalue" "5"
	"runtimeout" "-1"
	"scaleestimatedbycpu" "100"
	"scaleestimatedbymemory" "100"
	"showerrorwhenretrying" "1"
	"showoutputlogerror" "0"
	"startmaxjobsimmed" "1"
	"starttimeout" "300"
	"userquotaspace" "0"
	"userquotavalue" ""
	"usesameprocess" "1"
	"warndisklow" "0"
	"warnthresholdvalue" "100"
) )

;====================== Disabled items =========================================

;====================== Run Mode Options ======================================

;====================== Starting Point Info ======================================

;====================== Run command ============================================
ocnxlRun( ?mode 'sweepsAndCorners ?nominalCornerEnabled nil ?allCornersEnabled t ?allSweepsEnabled t)
ocnxlOutputSummary(?exprSummary t ?specSummary t ?detailed t ?wave t)
ocnxlOpenResults()

;====================== End XL Mode command ===================================
ocnxlEndXLMode("assembler")
