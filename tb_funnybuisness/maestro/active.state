ADE simulation setup
Test ee610_fall2025_jc9253_lib_tb_lab3_1: ee610_fall2025_jc9253_lib/tb_lab3/schematic, simulator spectre
  Models: /classes/ee620/tech/cds/gpdk045/GPDK045_v5/TECH/GPDK045/gpdk045_v_5_0/gpdk045/../models/spectre/gpdk045.scs[mc]
  Variables: VDD = 2; VIN_DC = 0.763
  Temperature: 27
  Analysis dc: sweep VIN_DC start=0 stop=2 step=10m (saves the operating point)
  Signals: /net3, /vin, /I7/IREF_OUT (terminal)
Test Lab3_DC_TRANS_ac: ee610_fall2025_jc9253_lib/tb_ota_stage/schematic, simulator spectre
  Models: /classes/ee620/tech/cds/gpdk045/GPDK045_v5/TECH/GPDK045/gpdk045_v_5_0/gpdk045/../models/spectre/gpdk045.scs[tt]
  Variables: IREF_OUT = 10u; VDD = 1.2; VIN_AC = 0.8; VIN_DC = 0.6
  Temperature: 27
  Analysis ac: start=1 stop=10G dec=20
  Output VIN_PP = (ymax(VT(vin)) - ymin(VT(vin)))
  Output VOUT_Mag = dB20(VF("/vout"))
  Output VOUT_Phase = phase(VF("/vout"))
  Output VOUT_PP = (ymax(VT("/vout")) - ymin(VT("/vout")))
  Output Av = (VOUT_PP / VIN_PP)
  Output VOUT_NoDC = (VT("/vout") - average(VT("/vout")))
  Output VIN_NoDC = (VT(vin) - average(VT(vin)))
  Output VIN_Cros = cross(VIN_NoDC 0 5 "rising" nil nil nil)
  Output VOUT_Cros = cross(VOUT_NoDC 0 5 "rising" nil nil nil)
  Output cross_delta = (VOUT_Cros - VIN_Cros)
  Output phase shift = (360 - (cross_delta * VAR("Fin") * 360))
  Signals: /vout, /vin2 as vin, /ota/IREF_OUT
Test OTA_DC_TRANS_ac: ee610_fall2025_jc9253_lib/tb_ota_stage/schematic, simulator spectre
  Models: /classes/ee620/tech/cds/gpdk045/GPDK045_v5/TECH/GPDK045/gpdk045_v_5_0/gpdk045/../models/spectre/gpdk045.scs[tt]
  Variables: Wu = 1u; Fin = 10M; IREF_OUT = 10u; VIN_AC = 1.2u; VIN_DC = 1.6
  Temperature: 27
  Analysis dc: (saves the operating point)
  Output gm0,1 = (OP("/ota/M1" "gm") / OP("/ota/M1" "id"))
  Output gm4,5 = (OP("/ota/M4" "gm") / OP("/ota/M4" "id"))
  Output av1_pp = (ymax(VT("/ota/av1")) - ymin(VT("/ota/av1")))
  Output av1_NoDC = (VT("/ota/av1") - average(VT("/ota/av1")))
  Output av2_pp = (ymax(VT("/ota/av2")) - ymin(VT("/ota/av2")))
  Output av3_pp = (ymax(VT("/ota/av3")) - ymin(VT("/ota/av3")))
  Output gm2,7 = (OP("/ota/M7" "gm") / OP("/ota/M7" "id"))
  Output VIN_PP = (ymax(VT("/vin2")) - ymin(VT("/vin2")))
  Output VOUT_Mag = dB20(VF("/vout"))
  Output VOUT_Phase = phase(VF("/vout"))
  Output VOUT_PP = (ymax(VT("/vout")) - ymin(VT("/vout")))
  Output Av = (VOUT_PP / VIN_PP)
  Output VOUT_NoDC = (VT("/vout") - average(VT("/vout")))
  Output VIN_NoDC = (VT("/vin2") - average(VT("/vin2")))
  Output VIN_Cros = cross(VIN_NoDC 0 5 "rising" nil nil nil)
  Output VOUT_Cros = cross(VOUT_NoDC 0 5 "rising" nil nil nil)
  Output cross_delta = (VOUT_Cros - VIN_Cros)
  Output phase shift = (360 - (cross_delta * VAR("Fin") * 360))
  Output vgs_0.7 = (OP("/ota/M0" "vgs"))
  Signals: /net2, /vin2 as vin, /vin1, /ota/IREF_OUT as v_headroom, /ota/net2 as Vgs_0.7, /ota/av1, /ota/av2, /ota/av3, /vout
