ADE simulation setup
Run mode: Single Run, Sweeps and Corners
Tests:
  OTA_DC_TRANS_ac: ee610_fall2025_jc9253_lib/tb_ota_stage/schematic, simulator spectre
    Variables: Fin = 10M; IREF_OUT = 10u; VIN_AC = 1.2u; VIN_DC = 1.6; Wu = 1u
    Outputs: (VDC); IDC("/I7/IREF_OUT"); (dB20); VOUT_Mag; VOUT_Phase; ymax(VT("/vout")); VOUT_PP; VIN_PP; Av; VT(out); VT("/vout"); (VT("/vout") - (average)); VOUT_NoDC; (VT("/vout") - average(VT("/vout"))); VIN_NoDC; VIN_Cros; VOUT_Cros; cross_delta; phase shift [Degree]; vin; v_headroom; /vin1; /ota/av1; /ota/av2; gm0,1; av1_pp; av1_NoDC; gm4,5; vgs_0.7; /net2; Vgs_0.7; av3_pp; av2_pp; gm2,7
Corners (nominal off):
  model folders: /classes/ee620/tech/cds/gpdk045/GPDK045_v5/TECH/GPDK045/gpdk045_v_5_0/gpdk045/../models/spectre
  Typical: temperature=27; VDD=2; gpdk045.scs[tt]
