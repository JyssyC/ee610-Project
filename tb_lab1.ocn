;====================Set to Maestro mode assembler =============================
ocnSetXLMode("assembler")
ocnxlProjectDir( "./simulation" )
ocnxlTargetCellView( "ee610_fall2025_jc9253_lib" "tb_lab1" "maestro" )
ocnxlResultsLocation( "" )
ocnxlSimResultsLocation( "" )
ocnxlMaxJobFail( 20 )

;====================== Tests setup ============================================

;---------- Test "VGS_SWP" -------------
ocnxlBeginTest("VGS_SWP")
simulator( 'spectre )
design( "ee610_fall2025_jc9253_lib" "tb_lab1" "schematic")
modelFile(
    '("/classes/ee620/tech/cds/gpdk045/GPDK045_v5/TECH/GPDK045/gpdk045_v_5_0/gpdk045/../models/spectre/gpdk045.scs" "mc")
)
analysis('dc ?saveOppoint t  ?param "VGS"  ?start "0"
		?stop "1"  ?step "10m"  )
desVar(	  "VDS" 1	)
desVar(	  "VGS" 0.7	)
envOption(
	'analysisOrder  list("pz" "dcmatch" "stb" "tran" "envlp" "ac" "dc" "lf" "noise" "xf" "sp" "pss" "pac" "pstb" "pnoise" "pxf" "psp" "qpss" "qpac" "qpnoise" "qpxf" "qpsp" "hb" "hbac" "hbstb" "hbnoise" "hbxf" "sens" "acmatch")
)
option(	'pzSeverity  "None"
	'noiseSeverity  "None"
	'spSeverity  "None"
	'acSeverity  "None"
	'dcOpSeverity  "None"
	'dcSeverity  "None"
	'tranSeverity  "None"
)
saveOption( ?infoOptions list(list("modelParameter" "models" "rawfile" "" "" "" t) list("element" "inst" "rawfile" "" "" "" t) list("outputParameter" "output" "rawfile" "" "" "" t) list("designParamVals" "parameters" "rawfile" "" "" "" t) list("primitives" "primitives" "rawfile" "" "" "" t) list("subckts" "subckts" "rawfile" "" "" "" t) list("asserts" "assert" "rawfile" "" "" "" nil) list("extremeinfo" "all" "logfile" "" "yes" "" nil) list("allcap" "allcap" "file" "" "" "" nil) list("simStatistics" "simstat" "rawfile" "" "" "" nil) list("<Click_To_Add>" "none" "rawfile" "" "" "" nil) ) )
save( 'i "/M0/D" )
saveOpPoint( "/M0" ?operatingPoints "gds gm ids" )
temp( 27 )
ocnxlOutputExpr( "OS(\"/M0\" \"ids\")" ?name "M0_ids_swp" ?plot t ?save t ?evalType 'point)
ocnxlOutputExpr( "deriv(M0_ids_swp)" ?name "M0_gm_swp_deriv" ?plot t)
ocnxlOutputExpr( "OP(\"/M0\" \"gm\")" ?name "M0_gm" ?plot t ?evalType 'point)
ocnxlOutputExpr( "OP(\"/M0\" \"vth\")" ?name "M0_vth" ?plot t ?evalType 'point)
ocnxlOutputExpr( "(1 / OP(\"/M0\" \"gds\"))" ?name "M0_r0" ?plot t ?evalType 'point)
ocnxlOutputExpr( "OP(\"/M0\" \"betaeff\")" ?name "M0_betaeff" ?plot t ?evalType 'point)
ocnxlOutputExpr( "OP(\"/M0\" \"ids\")" ?name "M0_ids" ?plot t ?evalType 'point)
ocnxlOutputTerminal( "/M0/D" ?plot t ?save t)
ocnxlOutputExpr( "OS(\"/M0\" \"gm\")" ?name "M0_gm_swp" ?plot t ?evalType 'point)
ocnxlOutputExpr( "(1 / OS(\"/M0\" \"gds\"))" ?name "M0_r0_swp" ?plot t ?evalType 'point)
ocnxlEndTest() ; "VGS_SWP"

;---------- Test "VDS_SWP" -------------
ocnxlBeginTest("VDS_SWP")
simulator( 'spectre )
design( "ee610_fall2025_jc9253_lib" "tb_lab1" "schematic")
modelFile(
    '("/classes/ee620/tech/cds/gpdk045/GPDK045_v5/TECH/GPDK045/gpdk045_v_5_0/gpdk045/../models/spectre/gpdk045.scs" "mc")
)
analysis('dc ?saveOppoint t  ?param "VDS"  ?start "0"
		?stop "1"  ?step "10m"  )
desVar(	  "VDS" 1	)
desVar(	  "VGS" 0.7	)
envOption(
	'analysisOrder  list("pz" "dcmatch" "stb" "tran" "envlp" "ac" "dc" "lf" "noise" "xf" "sp" "pss" "pac" "pstb" "pnoise" "pxf" "psp" "qpss" "qpac" "qpnoise" "qpxf" "qpsp" "hb" "hbac" "hbstb" "hbnoise" "hbxf" "sens" "acmatch")
)
option(	'pzSeverity  "None"
	'noiseSeverity  "None"
	'spSeverity  "None"
	'acSeverity  "None"
	'dcOpSeverity  "None"
	'dcSeverity  "None"
	'tranSeverity  "None"
)
saveOption( ?infoOptions list(list("modelParameter" "models" "rawfile" "" "" "" t) list("element" "inst" "rawfile" "" "" "" t) list("outputParameter" "output" "rawfile" "" "" "" t) list("designParamVals" "parameters" "rawfile" "" "" "" t) list("primitives" "primitives" "rawfile" "" "" "" t) list("subckts" "subckts" "rawfile" "" "" "" t) list("asserts" "assert" "rawfile" "" "" "" nil) list("extremeinfo" "all" "logfile" "" "yes" "" nil) list("allcap" "allcap" "file" "" "" "" nil) list("simStatistics" "simstat" "rawfile" "" "" "" nil) list("<Click_To_Add>" "none" "rawfile" "" "" "" nil) ) )
save( 'i "/M0/D" )
saveOpPoint( "/M0" ?operatingPoints "gds gm ids" )
temp( 27 )
ocnxlOutputExpr( "OS(\"/M0\" \"ids\")" ?name "M0_ids_swp" ?plot t ?save t ?evalType 'point)
ocnxlOutputExpr( "deriv(M0_ids_swp)" ?name "M0_gm_swp_deriv" ?plot t)
ocnxlOutputExpr( "OP(\"/M0\" \"gm\")" ?name "M0_gm" ?plot t ?evalType 'point)
ocnxlOutputExpr( "OP(\"/M0\" \"vth\")" ?name "M0_vth" ?plot t ?evalType 'point)
ocnxlOutputExpr( "(1 / OP(\"/M0\" \"gds\"))" ?name "M0_r0" ?plot t ?evalType 'point)
ocnxlOutputExpr( "OP(\"/M0\" \"betaeff\")" ?name "M0_betaeff" ?plot t ?evalType 'point)
ocnxlOutputExpr( "OP(\"/M0\" \"ids\")" ?name "M0_ids" ?plot t ?evalType 'point)
ocnxlOutputTerminal( "/M0/D" ?plot t ?save t)
ocnxlOutputExpr( "OS(\"/M0\" \"gm\")" ?name "M0_gm_swp" ?plot t ?evalType 'point)
ocnxlOutputExpr( "(1 / OS(\"/M0\" \"gds\"))" ?name "M0_r0_swp" ?plot t ?evalType 'point)
ocnxlEndTest() ; "VDS_SWP"

;====================== Sweeps setup ===========================================

;====================== Model Group setup ==========================================

;====================== Corners setup ==========================================

;====================== Checks and Asserts setup ============================================
ocnxlPutChecksAsserts(?netlist nil)

;====================== Job setup ==============================================
ocnxlJobSetup( '(
	"blockemail" "1"
	"communicationtimeout" "180"
	"configuretimeout" "300"
	"defaultcpuvalue" "1"
	"defaultmemoryvalue" "1000"
	"distributionmethod" "Local"
	"jobruntype" "LSCS"
	"estimatecpuvalue" ""
	"estimatememoryvalue" ""
	"estimationsimulationmode" "0"
	"lingertimeout" "300"
	"maxjobs" "1"
	"name" "Maestro Default"
	"preemptivestart" "1"
	"providecpuandmemorydata" "1"
	"reconfigureimmediately" "1"
	"runpointsvalue" "5"
	"runtimeout" "-1"
	"scaleestimatedbycpu" "100"
	"scaleestimatedbymemory" "100"
	"showerrorwhenretrying" "1"
	"showoutputlogerror" "0"
	"startmaxjobsimmed" "1"
	"starttimeout" "300"
	"userquotaspace" "0"
	"userquotavalue" ""
	"usesameprocess" "1"
	"warndisklow" "0"
	"warnthresholdvalue" "100"
) )

;====================== Disabled items =========================================

;====================== Run Mode Options ======================================

;====================== Starting Point Info ======================================

;====================== Run command ============================================
ocnxlRun( ?mode 'sweepsAndCorners ?nominalCornerEnabled t ?allCornersEnabled t ?allSweepsEnabled t)
ocnxlOutputSummary(?exprSummary t ?specSummary t ?detailed t ?wave t)
ocnxlOpenResults()

;====================== End XL Mode command ===================================
ocnxlEndXLMode("assembler")
