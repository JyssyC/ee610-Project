;====================Set to Maestro mode assembler =============================
ocnSetXLMode("assembler")
ocnxlProjectDir( "./simulation" )
ocnxlTargetCellView( "ee610_fall2025_jc9253_lib" "tb_lab5" "maestro" )
ocnxlResultsLocation( "" )
ocnxlSimResultsLocation( "" )
ocnxlMaxJobFail( 20 )

;====================== Tests setup ============================================

;---------- Test "Lab5_DC_TRANS_ac" -------------
ocnxlBeginTest("Lab5_DC_TRANS_ac")
simulator( 'spectre )
design( "ee610_fall2025_jc9253_lib" "tb_lab5" "schematic")
modelFile(
    '("/classes/ee620/tech/cds/gpdk045/GPDK045_v5/TECH/GPDK045/gpdk045_v_5_0/gpdk045/../models/spectre/gpdk045.scs" "tt")
)
analysis('dc ?saveOppoint t  )
desVar(	  "VDD" 2	)
desVar(	  "R_LD" 5k	)
envOption(
	'analysisOrder  list("pz" "dcmatch" "stb" "tran" "envlp" "ac" "dc" "lf" "noise" "xf" "sp" "pss" "pac" "pstb" "pnoise" "pxf" "psp" "qpss" "qpac" "qpnoise" "qpxf" "qpsp" "hb" "hbac" "hbstb" "hbnoise" "hbxf" "sens" "acmatch")
)
option(	'pzSeverity  "None"
	'noiseSeverity  "None"
	'spSeverity  "None"
	'acSeverity  "None"
	'dcOpSeverity  "None"
	'dcSeverity  "None"
	'tranSeverity  "None"
)
saveOption( ?infoOptions list(list("modelParameter" "models" "rawfile" "" "" "" t) list("element" "inst" "rawfile" "" "" "" t) list("outputParameter" "output" "rawfile" "" "" "" t) list("designParamVals" "parameters" "rawfile" "" "" "" t) list("primitives" "primitives" "rawfile" "" "" "" t) list("subckts" "subckts" "rawfile" "" "" "" t) list("asserts" "assert" "rawfile" "" "" "" nil) list("extremeinfo" "all" "logfile" "" "yes" "" nil) list("allcap" "allcap" "file" "" "" "" nil) list("simStatistics" "simstat" "rawfile" "" "" "" nil) list("<Click_To_Add>" "none" "rawfile" "" "" "" nil) ) )
save( 'v "/I0/net2" "/vout" "/I0/net1" )
save( 'i "/I0/IREF_OUT" )
temp( 27 )
ocnxlOutputExpr( "VDC(\"/I0/net2\")" ?name "VD" ?plot t ?save t ?evalType 'point)
ocnxlOutputExpr( "VDC(\"/I0/net1\")" ?name "VS" ?plot t ?save t ?evalType 'point)
ocnxlOutputExpr( "(VD - VS)" ?name "Headrom Vds" ?plot t ?evalType 'point)
ocnxlOutputTerminal( "/I0/IREF_OUT" ?plot t ?save t)
ocnxlOutputSignal( "/vout" ?plot t ?save t)
ocnxlOutputExpr( "VDC(\"/vout\")" ?plot t ?evalType 'point)
ocnxlOutputSignal( "/I0/net1" ?save t)
ocnxlOutputExpr( "IDC(\"/I0/IREF_OUT\")" ?plot t ?evalType 'point)
ocnxlEndTest() ; "Lab5_DC_TRANS_ac"

;====================== Sweeps setup ===========================================

;====================== Model Group setup ==========================================
ocnxlModelGroup( "/classes/ee620/tech/cds/gpdk045/GPDK045_v5/TECH/GPDK045/gpdk045_v_5_0/gpdk045/../models/spectre/gpdk045.scs"
   '(
   )
)

;====================== Corners setup ==========================================
ocnxlCorner( "Typical"
   '(
      ("variable" "temperature" "27")
      ("variable" "VDD" "2")
      ("model" "/classes/ee620/tech/cds/gpdk045/GPDK045_v5/TECH/GPDK045/gpdk045_v_5_0/gpdk045/../models/spectre/gpdk045.scs" ?section "\"tt\"")
      ("modelGroup" "")
   )
)
ocnxlCorner( "PVT"
   '(
      ("variable" "temperature" "0 27 100")
      ("variable" "VDD" "1.8 2 2.2")
      ("model" "/classes/ee620/tech/cds/gpdk045/GPDK045_v5/TECH/GPDK045/gpdk045_v_5_0/gpdk045/../models/spectre/gpdk045.scs" ?section "\"tt\" \"ss\" \"sf\" \"fs\" \"ff\"")
      ("modelGroup" "")
   )
)
ocnxlCorner( "MC"
   '(
      ("variable" "temperature" "27")
      ("variable" "VDD" "2.0")
      ("model" "/classes/ee620/tech/cds/gpdk045/GPDK045_v5/TECH/GPDK045/gpdk045_v_5_0/gpdk045/../models/spectre/gpdk045.scs" ?section "\"mc\"")
      ("modelGroup" "")
   )
)

;====================== Checks and Asserts setup ============================================
ocnxlPutChecksAsserts(?netlist nil)

;====================== Test v/s corners setup =================================

;====================== Job setup ==============================================
ocnxlJobSetup( '(
	"blockemail" "1"
	"communicationtimeout" "180"
	"configuretimeout" "300"
	"defaultcpuvalue" "1"
	"defaultmemoryvalue" "1000"
	"distributionmethod" "Local"
	"jobruntype" "LSCS"
	"estimatecpuvalue" ""
	"estimatememoryvalue" ""
	"estimationsimulationmode" "0"
	"lingertimeout" "300"
	"maxjobs" "1"
	"name" "Maestro Default"
	"preemptivestart" "1"
	"providecpuandmemorydata" "1"
	"reconfigureimmediately" "1"
	"runpointsvalue" "5"
	"runtimeout" "-1"
	"scaleestimatedbycpu" "100"
	"scaleestimatedbymemory" "100"
	"showerrorwhenretrying" "1"
	"showoutputlogerror" "0"
	"startmaxjobsimmed" "1"
	"starttimeout" "300"
	"userquotaspace" "0"
	"userquotavalue" ""
	"usesameprocess" "1"
	"warndisklow" "0"
	"warnthresholdvalue" "100"
) )

;====================== Disabled items =========================================
ocnxlDisableCorner("Typical")
ocnxlDisableCorner("PVT")

;====================== Run Mode Options ======================================

;====================== Starting Point Info ======================================

;====================== Run command ============================================
ocnxlRun( ?mode 'monteCarlo ?nominalCornerEnabled t ?allCornersEnabled t ?allSweepsEnabled t)
ocnxlOutputSummary(?yieldSummary t ?exprSummary nil ?specSummary nil ?detailed nil)
ocnxlOpenResults()

;====================== End XL Mode command ===================================
ocnxlEndXLMode("assembler")
